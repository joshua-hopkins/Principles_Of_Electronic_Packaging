# Ansys Electronics Desktop project, version 2024.2
materials:
  vacuum: permittivity=1
  copper: permeability=0.999991 conductivity=58000000
  gold: permeability=0.99996 conductivity=41000000
  aluminum_no2_EC: permeability=1.000021 conductivity=33000000
  epoxy_Kevlar_xy: permittivity=3.6
  modified_epoxy: permittivity=4.2 dielectric_loss_tangent=0.02
  silicon: permittivity=11.9

design DIP8 (Q3D Extractor, model units mm)
options: SParamCalcMethod=EqTransLine Calculate_Lossy_Dielectrics
geometry:
  die [silicon] = imported_body(G:\College\Virginia_Tech\Spring_2025\Principles_Of_Electronic_Packaging\Group_Work_1\06-08_DIP8_Q3D.step)
  Pad, Lead_8, Lead_7, Lead_6, Lead_5, Lead_4, Lead_3 [copper, non-model] = imported_body(G:\College\Virginia_Tech\Spring_2025\Principles_Of_Electronic_Packaging\Group_Work_1\06-08_DIP8_Q3D.step)
  Lead_2, Lead_1 [copper] = imported_body(G:\College\Virginia_Tech\Spring_2025\Principles_Of_Electronic_Packaging\Group_Work_1\06-08_DIP8_Q3D.step)
  EMC_top, EMC_mid, EMC_bot [modified_epoxy] = imported_body(G:\College\Virginia_Tech\Spring_2025\Principles_Of_Electronic_Packaging\Group_Work_1\06-08_DIP8_Q3D.step)
  Bondwire_8, Bondwire_7, Bondwire_6, Bondwire_5, Bondwire_4, Bondwire_3 [gold, non-model] = imported_body(G:\College\Virginia_Tech\Spring_2025\Principles_Of_Electronic_Packaging\Group_Work_1\06-08_DIP8_Q3D.step)
  Bondwire_2, Bondwire_1 [gold] = imported_body(G:\College\Virginia_Tech\Spring_2025\Principles_Of_Electronic_Packaging\Group_Work_1\06-08_DIP8_Q3D.step)
  Ellipse_8, Ellipse_7, Ellipse_6, Ellipse_5, Ellipse_4, Ellipse_3, Ellipse_2, Ellipse_1 = imported_body(G:\College\Virginia_Tech\Spring_2025\Principles_Of_Electronic_Packaging\Group_Work_1\06-08_DIP8_Q3D.step)
  group 0608_DIP8_Q3D = die, Pad, Lead_8, Lead_7, Lead_6, Lead_5, Lead_4, Lead_3, Lead_2, Lead_1, EMC_top, EMC_mid, EMC_bot, Bondwire_8, Bondwire_7, Bondwire_6, Bondwire_5, Bondwire_4, Bondwire_3, Bondwire_2, Bondwire_1, Ellipse_8, Ellipse_7, Ellipse_6, Ellipse_5, Ellipse_4, Ellipse_3, Ellipse_2, Ellipse_1
boundaries and excitations:
  Bondwire_2: SignalNet Objects=[Lead_2, Bondwire_2]
  Bondwire_1: SignalNet Objects=[Lead_1, Bondwire_1]
source amplitudes:
  Bondwire_1: CG Fields 0V 0deg
  Bondwire_2: CG Fields 1V 0deg
